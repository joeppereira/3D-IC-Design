* Smart Simulation Deck for CXL_Switch_SoP_1TB_V4_PowerStacked
* Generated by Autonomous Architect (Enterprise Mode)

.PARAM VDD_NOM=0.8

* --- REGION OF INTEREST (ROI): HIGH DETAIL ---
XSERDES_N_0 TX_IN_N0 TX_OUT_N0 SERDES_LANE .TEMP=25.0 .VDD=0.797
XSERDES_N_1 TX_IN_N1 TX_OUT_N1 SERDES_LANE .TEMP=25.5 .VDD=0.797
XSERDES_N_2 TX_IN_N2 TX_OUT_N2 SERDES_LANE .TEMP=26.0 .VDD=0.797
XSERDES_N_3 TX_IN_N3 TX_OUT_N3 SERDES_LANE .TEMP=26.5 .VDD=0.797
XSERDES_N_4 TX_IN_N4 TX_OUT_N4 SERDES_LANE .TEMP=27.0 .VDD=0.797
XSERDES_N_5 TX_IN_N5 TX_OUT_N5 SERDES_LANE .TEMP=27.5 .VDD=0.797
XSERDES_N_6 TX_IN_N6 TX_OUT_N6 SERDES_LANE .TEMP=28.0 .VDD=0.797
XSERDES_N_7 TX_IN_N7 TX_OUT_N7 SERDES_LANE .TEMP=28.5 .VDD=0.797

* --- QUIET ZONES: LUMPED MODELS ---
XCORE_QUIET CORE_INPUT CORE_OUTPUT COMPACT_CORE_MODEL .TEMP=45.0 .VDD=0.79

* --- CILD: CONTROLLED IMPEDANCE LINES ---
W_LINK1 RX_IN TX_OUT TLINE_MODEL L=300m

.MODEL SERDES_LANE PMOS (LEVEL=54 ...)
.MODEL COMPACT_CORE_MODEL R=100 C=10p
